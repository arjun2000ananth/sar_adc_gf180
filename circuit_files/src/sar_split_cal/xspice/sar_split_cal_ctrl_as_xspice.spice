* include INSTEAD of gate/sar_split_cal_ctrl.spice to use the XSPICE gate-level view (GENERATED)
.include sar_split_cal_ctrl_xspice.spice
.subckt sar_split_cal_ctrl VDD VSS clk rst_n start comp cal_en cal_we cal_addr3 cal_addr2 cal_addr1 cal_addr0 cal_wdata17 cal_wdata16 cal_wdata15 cal_wdata14 cal_wdata13 cal_wdata12 cal_wdata11 cal_wdata10 cal_wdata9 cal_wdata8 cal_wdata7 cal_wdata6 cal_wdata5 cal_wdata4 cal_wdata3 cal_wdata2 cal_wdata1 cal_wdata0 sample rstf comp_clk busy valid raw_stb sat bp9 bp8 bp7 bp6 bp5 bpr bp4 bp3 bp2 bp1 bp0 bn9 bn8 bn7 bn6 bn5 bnr bn4 bn3 bn2 bn1 bn0 code9 code8 code7 code6 code5 code4 code3 code2 code1 code0 raw11 raw10 raw9 raw8 raw7 raw6 raw5 raw4 raw3 raw2 raw1 raw0
xg VDD VSS clk rst_n start comp cal_en cal_we cal_addr3 cal_addr2 cal_addr1 cal_addr0 cal_wdata17 cal_wdata16 cal_wdata15 cal_wdata14 cal_wdata13 cal_wdata12 cal_wdata11 cal_wdata10 cal_wdata9 cal_wdata8 cal_wdata7 cal_wdata6 cal_wdata5 cal_wdata4 cal_wdata3 cal_wdata2 cal_wdata1 cal_wdata0 sample rstf comp_clk busy valid raw_stb sat bp9 bp8 bp7 bp6 bp5 bpr bp4 bp3 bp2 bp1 bp0 bn9 bn8 bn7 bn6 bn5 bnr bn4 bn3 bn2 bn1 bn0 code9 code8 code7 code6 code5 code4 code3 code2 code1 code0 raw11 raw10 raw9 raw8 raw7 raw6 raw5 raw4 raw3 raw2 raw1 raw0 sar_split_cal_ctrl_xspice
.ends sar_split_cal_ctrl
